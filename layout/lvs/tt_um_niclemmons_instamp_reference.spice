** sch_path: /home/lemmons/ece5120/instamp/xschem/instamp.sch
.subckt instamp Vp Vn Vmid Vout Rgp Rgn Vref VDD GND
*.PININFO Vp:I Vn:I Vmid:I Vout:O Rgp:B Rgn:B Vref:O VDD:B GND:B
x1 Vp Rgp Vout Vref VDD GND opamp_x
x2 Vn Rgn Vout2 Vref VDD GND opamp_x
x5 VDD Vref GND bandgap_x
XR1 Vout2 Rgn GND sky130_fd_pr__res_high_po_0p69 L=17.13 mult=1 m=1
XR2 Vout2 Rgp GND sky130_fd_pr__res_high_po_0p69 L=17.13 mult=1 m=1
XR3 Vmid Rgn GND sky130_fd_pr__res_high_po_0p35 L=35.36 mult=1 m=1
XR4 Vout Rgp GND sky130_fd_pr__res_high_po_0p35 L=35.36 mult=1 m=1
.ends

* expanding   symbol:  opamp_x.sym # of pins=6
** sym_path: /home/lemmons/ece5120/instamp/xschem/opamp_x.sym
** sch_path: /home/lemmons/ece5120/instamp/xschem/opamp_x.sch
.subckt opamp_x Vp Vn Vout Vref VDD GND
*.PININFO Vref:I Vp:I Vn:I Vout:I VDD:B GND:B
XM2 net1 Vref GND GND sky130_fd_pr__nfet_g5v0d10v5 L=5 W=2 nf=1 ad=0.58
+ as=0.58 pd=4.58 ps=4.58
+ nrd=0.145 nrs=0.145 sa=0 sb=0 sd=0 mult=1 m=1
XM4 net2 net2 VDD VDD sky130_fd_pr__pfet_g5v0d10v5 L=1 W=1 nf=1 ad=0.29
+ as=0.29 pd=2.58 ps=2.58
+ nrd=0.29 nrs=0.29 sa=0 sb=0 sd=0 mult=1 m=1
Vmeas_Iref net2 net1 0
.save i(vmeas_iref)
XM5 net3 net2 VDD VDD sky130_fd_pr__pfet_g5v0d10v5 L=1 W=1 nf=1 ad=0.29
+ as=0.29 pd=2.58 ps=2.58
+ nrd=0.29 nrs=0.29 sa=0 sb=0 sd=0 mult=1 m=1
XM6 net3 net3 net21 GND sky130_fd_pr__nfet_g5v0d10v5 L=.5 W=5 nf=1 ad=1.45
+ as=1.45 pd=10.58 ps=10.58
+ nrd=0.058 nrs=0.058 sa=0 sb=0 sd=0 mult=1 m=1
XM7 net21 net3 GND GND sky130_fd_pr__nfet_g5v0d10v5 L=1.5 W=1.5 nf=1 ad=0.435
+ as=0.435 pd=3.58 ps=3.58
+ nrd=0.1933333333 nrs=0.1933333333 sa=0 sb=0 sd=0 mult=1 m=1
XM8 net5 net3 net4 GND sky130_fd_pr__nfet_g5v0d10v5 L=.5 W=5 nf=1 ad=1.45
+ as=1.45 pd=10.58 ps=10.58
+ nrd=0.058 nrs=0.058 sa=0 sb=0 sd=0 mult=1 m=1
XM9 net4 net3 GND GND sky130_fd_pr__nfet_g5v0d10v5 L=1.5 W=1.5 nf=1 ad=0.435
+ as=0.435 pd=3.58 ps=3.58
+ nrd=0.1933333333 nrs=0.1933333333 sa=0 sb=0 sd=0 mult=1 m=1
XM10 net5 net5 net6 VDD sky130_fd_pr__pfet_g5v0d10v5 L=1 W=20 nf=1 ad=5.8
+ as=5.8 pd=40.58 ps=40.58
+ nrd=0.0145 nrs=0.0145 sa=0 sb=0 sd=0 mult=1 m=1
XM11 net6 net5 VDD VDD sky130_fd_pr__pfet_g5v0d10v5 L=2 W=7.5 nf=1 ad=2.175
+ as=2.175 pd=15.58 ps=15.58
+ nrd=0.03866666667 nrs=0.03866666667 sa=0 sb=0 sd=0 mult=1 m=1
XM12 net7 net5 VDD VDD sky130_fd_pr__pfet_g5v0d10v5 L=2 W=7.5 nf=1 ad=2.175
+ as=2.175 pd=15.58 ps=15.58
+ nrd=0.03866666667 nrs=0.03866666667 sa=0 sb=0 sd=0 mult=2 m=2
XM13 net8 net5 net7 VDD sky130_fd_pr__pfet_g5v0d10v5 L=1 W=10 nf=1 ad=2.9
+ as=2.9 pd=20.58 ps=20.58
+ nrd=0.029 nrs=0.029 sa=0 sb=0 sd=0 mult=2 m=2
XM14 net10 Vp net8 VDD sky130_fd_pr__pfet_g5v0d10v5 L=1 W=10 nf=1 ad=2.9
+ as=2.9 pd=20.58 ps=20.58
+ nrd=0.029 nrs=0.029 sa=0 sb=0 sd=0 mult=6 m=6
XM15 net9 Vn net8 VDD sky130_fd_pr__pfet_g5v0d10v5 L=1 W=10 nf=1 ad=2.9
+ as=2.9 pd=20.58 ps=20.58
+ nrd=0.029 nrs=0.029 sa=0 sb=0 sd=0 mult=6 m=6
XM20 net11 net3 net9 GND sky130_fd_pr__nfet_g5v0d10v5 L=1.5 W=10 nf=1 ad=2.9
+ as=2.9 pd=20.58 ps=20.58
+ nrd=0.029 nrs=0.029 sa=0 sb=0 sd=0 mult=4 m=4
XM21 net9 net3 GND GND sky130_fd_pr__nfet_g5v0d10v5 L=1.5 W=2.5 nf=1 ad=0.725
+ as=0.725 pd=5.58 ps=5.58
+ nrd=0.116 nrs=0.116 sa=0 sb=0 sd=0 mult=1 m=1
XM22 net15 net3 net10 GND sky130_fd_pr__nfet_g5v0d10v5 L=1.5 W=10 nf=1 ad=2.9
+ as=2.9 pd=20.58 ps=20.58
+ nrd=0.029 nrs=0.029 sa=0 sb=0 sd=0 mult=4 m=4
XM23 net10 net3 GND GND sky130_fd_pr__nfet_g5v0d10v5 L=1.5 W=2.5 nf=1 ad=0.725
+ as=0.725 pd=5.58 ps=5.58
+ nrd=0.116 nrs=0.116 sa=0 sb=0 sd=0 mult=1 m=1
XM24 net13 net11 net12 VDD sky130_fd_pr__pfet_g5v0d10v5 L=.5 W=5 nf=1 ad=1.45
+ as=1.45 pd=10.58 ps=10.58
+ nrd=0.058 nrs=0.058 sa=0 sb=0 sd=0 mult=4 m=4
XM25 net12 net13 VDD VDD sky130_fd_pr__pfet_g5v0d10v5 L=1 W=5 nf=1 ad=1.45
+ as=1.45 pd=10.58 ps=10.58
+ nrd=0.058 nrs=0.058 sa=0 sb=0 sd=0 mult=4 m=4
XM26 net14 net13 VDD VDD sky130_fd_pr__pfet_g5v0d10v5 L=1 W=5 nf=1 ad=1.45
+ as=1.45 pd=10.58 ps=10.58
+ nrd=0.058 nrs=0.058 sa=0 sb=0 sd=0 mult=4 m=4
XM27 net17 net11 net14 VDD sky130_fd_pr__pfet_g5v0d10v5 L=.5 W=5 nf=1 ad=1.45
+ as=1.45 pd=10.58 ps=10.58
+ nrd=0.058 nrs=0.058 sa=0 sb=0 sd=0 mult=4 m=4
XM28 net16 net3 GND GND sky130_fd_pr__nfet_g5v0d10v5 L=5 W=1.5 nf=1 ad=0.435
+ as=0.435 pd=3.58 ps=3.58
+ nrd=0.1933333333 nrs=0.1933333333 sa=0 sb=0 sd=0 mult=1 m=1
XM29 net15 net16 net17 VDD sky130_fd_pr__pfet_g5v0d10v5 L=.5 W=15 nf=1 ad=4.35
+ as=4.35 pd=30.58 ps=30.58
+ nrd=0.01933333333 nrs=0.01933333333 sa=0 sb=0 sd=0 mult=8 m=8
XM30 net17 net20 net15 GND sky130_fd_pr__nfet_g5v0d10v5 L=.5 W=10 nf=1 ad=2.9
+ as=2.9 pd=20.58 ps=20.58
+ nrd=0.029 nrs=0.029 sa=0 sb=0 sd=0 mult=4 m=4
XM31 net16 net16 net18 VDD sky130_fd_pr__pfet_g5v0d10v5 L=.5 W=15 nf=1 ad=4.35
+ as=4.35 pd=30.58 ps=30.58
+ nrd=0.01933333333 nrs=0.01933333333 sa=0 sb=0 sd=0 mult=7 m=7
XM32 net18 net18 VDD VDD sky130_fd_pr__pfet_g5v0d10v5 L=.5 W=15 nf=1 ad=4.35
+ as=4.35 pd=30.58 ps=30.58
+ nrd=0.01933333333 nrs=0.01933333333 sa=0 sb=0 sd=0 mult=7 m=7
XM33 net19 net19 GND GND sky130_fd_pr__nfet_g5v0d10v5 L=.5 W=10 nf=1 ad=2.9
+ as=2.9 pd=20.58 ps=20.58
+ nrd=0.029 nrs=0.029 sa=0 sb=0 sd=0 mult=4 m=4
XM34 net20 net20 net19 GND sky130_fd_pr__nfet_g5v0d10v5 L=.5 W=10 nf=1 ad=2.9
+ as=2.9 pd=20.58 ps=20.58
+ nrd=0.029 nrs=0.029 sa=0 sb=0 sd=0 mult=4 m=4
XM35 net20 net5 VDD VDD sky130_fd_pr__pfet_g5v0d10v5 L=5 W=4 nf=1 ad=1.16
+ as=1.16 pd=8.58 ps=8.58
+ nrd=0.0725 nrs=0.0725 sa=0 sb=0 sd=0 mult=1 m=1
XC1 net15 Vout sky130_fd_pr__cap_mim_m3_1 W=30 L=30 MF=1 m=1
XC2 net17 Vout sky130_fd_pr__cap_mim_m3_1 W=30 L=30 MF=1 m=1
XM1 Vout net15 GND GND sky130_fd_pr__nfet_g5v0d10v5 L=.5 W=20 nf=1 ad=5.8
+ as=5.8 pd=40.58 ps=40.58
+ nrd=0.0145 nrs=0.0145 sa=0 sb=0 sd=0 mult=5 m=5
XM3 Vout net17 VDD VDD sky130_fd_pr__pfet_g5v0d10v5 L=.5 W=30 nf=1 ad=8.7
+ as=8.7 pd=60.58 ps=60.58
+ nrd=0.009666666667 nrs=0.009666666667 sa=0 sb=0 sd=0 mult=10 m=10
XR1 net11 net13 GND sky130_fd_pr__res_xhigh_po_0p35 L=10.13 mult=1 m=1
.ends

* expanding   symbol:  bandgap_x.sym # of pins=3
** sym_path: /home/lemmons/ece5120/instamp/xschem/bandgap_x.sym
** sch_path: /home/lemmons/ece5120/instamp/xschem/bandgap_x.sch
.subckt bandgap_x VDD Vref GND
*.PININFO VDD:I Vref:O GND:B
XM2 net2 net1 VDD VDD sky130_fd_pr__pfet_g5v0d10v5 L=1 W=1 nf=1 ad=0.29
+ as=0.29 pd=2.58 ps=2.58
+ nrd=0.29 nrs=0.29 sa=0 sb=0 sd=0 mult=1 m=1
XM4 net2 Vref net4 GND sky130_fd_pr__nfet_g5v0d10v5 L=1 W=20 nf=1 ad=5.8
+ as=5.8 pd=40.58 ps=40.58
+ nrd=0.0145 nrs=0.0145 sa=0 sb=0 sd=0 mult=1 m=1
XM1 net1 net1 VDD VDD sky130_fd_pr__pfet_g5v0d10v5 L=1 W=1 nf=1 ad=0.29
+ as=0.29 pd=2.58 ps=2.58
+ nrd=0.29 nrs=0.29 sa=0 sb=0 sd=0 mult=1 m=1
XM5 net3 net1 VDD VDD sky130_fd_pr__pfet_g5v0d10v5 L=1 W=1 nf=1 ad=0.29
+ as=0.29 pd=2.58 ps=2.58
+ nrd=0.29 nrs=0.29 sa=0 sb=0 sd=0 mult=1 m=1
XM3 net6 net9 net3 VDD sky130_fd_pr__pfet_g5v0d10v5 L=1 W=20 nf=1 ad=5.8
+ as=5.8 pd=40.58 ps=40.58
+ nrd=0.0145 nrs=0.0145 sa=0 sb=0 sd=0 mult=1 m=1
XM6 net5 net7 net3 VDD sky130_fd_pr__pfet_g5v0d10v5 L=1 W=20 nf=1 ad=5.8
+ as=5.8 pd=40.58 ps=40.58
+ nrd=0.0145 nrs=0.0145 sa=0 sb=0 sd=0 mult=1 m=1
XM7 Vref net2 VDD VDD sky130_fd_pr__pfet_g5v0d10v5 L=0.5 W=20 nf=1 ad=5.8
+ as=5.8 pd=40.58 ps=40.58
+ nrd=0.0145 nrs=0.0145 sa=0 sb=0 sd=0 mult=1 m=1
XM8 net1 Vref net14 GND sky130_fd_pr__nfet_g5v0d10v5 L=1 W=5 nf=1 ad=1.45
+ as=1.45 pd=10.58 ps=10.58
+ nrd=0.058 nrs=0.058 sa=0 sb=0 sd=0 mult=1 m=1
XM9 net2 net2 net10 GND sky130_fd_pr__nfet_g5v0d10v5 L=10 W=0.44 nf=1 ad=0.1276
+ as=0.1276 pd=1.46 ps=1.46
+ nrd=0.6590909091 nrs=0.6590909091 sa=0 sb=0 sd=0 mult=1 m=1
XM10 net4 net6 GND GND sky130_fd_pr__nfet_g5v0d10v5 L=1 W=20 nf=1 ad=5.8
+ as=5.8 pd=40.58 ps=40.58
+ nrd=0.0145 nrs=0.0145 sa=0 sb=0 sd=0 mult=1 m=1
XM11 net6 net5 GND GND sky130_fd_pr__nfet_g5v0d10v5 L=1 W=20 nf=1 ad=5.8
+ as=5.8 pd=40.58 ps=40.58
+ nrd=0.0145 nrs=0.0145 sa=0 sb=0 sd=0 mult=1 m=1
XM12 net5 net5 GND GND sky130_fd_pr__nfet_g5v0d10v5 L=1 W=20 nf=1 ad=5.8
+ as=5.8 pd=40.58 ps=40.58
+ nrd=0.0145 nrs=0.0145 sa=0 sb=0 sd=0 mult=1 m=1
XQ1 GND GND net8 sky130_fd_pr__pnp_05v5_W3p40L3p40 m=24 mult=24
XQ2 GND GND net7 sky130_fd_pr__pnp_05v5_W3p40L3p40 m=1 mult=1
XM13 net10 net2 net11 GND sky130_fd_pr__nfet_g5v0d10v5 L=10 W=0.44 nf=1 ad=0.1276
+ as=0.1276 pd=1.46 ps=1.46
+ nrd=0.6590909091 nrs=0.6590909091 sa=0 sb=0 sd=0 mult=1 m=1
XM14 net11 net2 net12 GND sky130_fd_pr__nfet_g5v0d10v5 L=10 W=0.44 nf=1 ad=0.1276
+ as=0.1276 pd=1.46 ps=1.46
+ nrd=0.6590909091 nrs=0.6590909091 sa=0 sb=0 sd=0 mult=1 m=1
XM15 net12 net2 net13 GND sky130_fd_pr__nfet_g5v0d10v5 L=10 W=0.44 nf=1 ad=0.1276
+ as=0.1276 pd=1.46 ps=1.46
+ nrd=0.6590909091 nrs=0.6590909091 sa=0 sb=0 sd=0 mult=1 m=1
XM16 net13 net2 net15 GND sky130_fd_pr__nfet_g5v0d10v5 L=10 W=0.44 nf=1 ad=0.1276
+ as=0.1276 pd=1.46 ps=1.46
+ nrd=0.6590909091 nrs=0.6590909091 sa=0 sb=0 sd=0 mult=1 m=1
XR4 net9 Vref GND sky130_fd_pr__res_high_po_0p35 L=20.36 mult=1 m=1
XR6 net7 Vref GND sky130_fd_pr__res_high_po_0p35 L=20.36 mult=1 m=1
XR1 net8 net9 GND sky130_fd_pr__res_high_po_0p35 L=3.5 mult=1 m=1
XM17 net15 net2 net16 GND sky130_fd_pr__nfet_g5v0d10v5 L=10 W=0.44 nf=1 ad=0.1276
+ as=0.1276 pd=1.46 ps=1.46
+ nrd=0.6590909091 nrs=0.6590909091 sa=0 sb=0 sd=0 mult=1 m=1
XM18 net16 net2 net17 GND sky130_fd_pr__nfet_g5v0d10v5 L=10 W=0.44 nf=1 ad=0.1276
+ as=0.1276 pd=1.46 ps=1.46
+ nrd=0.6590909091 nrs=0.6590909091 sa=0 sb=0 sd=0 mult=1 m=1
XM19 net17 net2 net18 GND sky130_fd_pr__nfet_g5v0d10v5 L=10 W=0.44 nf=1 ad=0.1276
+ as=0.1276 pd=1.46 ps=1.46
+ nrd=0.6590909091 nrs=0.6590909091 sa=0 sb=0 sd=0 mult=1 m=1
XM20 net18 net2 net19 GND sky130_fd_pr__nfet_g5v0d10v5 L=10 W=0.44 nf=1 ad=0.1276
+ as=0.1276 pd=1.46 ps=1.46
+ nrd=0.6590909091 nrs=0.6590909091 sa=0 sb=0 sd=0 mult=1 m=1
XM21 net19 net2 GND GND sky130_fd_pr__nfet_g5v0d10v5 L=10 W=0.44 nf=1 ad=0.1276
+ as=0.1276 pd=1.46 ps=1.46
+ nrd=0.6590909091 nrs=0.6590909091 sa=0 sb=0 sd=0 mult=1 m=1
XR3 GND net14 GND sky130_fd_pr__res_high_po_0p35 L=43.01 mult=1 m=1
.ends

* Tiny Tapeout schematic reference
.subckt tt_um_niclemmons_instamp clk ena rst_n ua[0] ua[1] ua[2] ua[3] ua[4] ua[5]
+ ua[6] ua[7] ui_in[0] ui_in[1] ui_in[2] ui_in[3] ui_in[4] ui_in[5]
+ ui_in[6] ui_in[7] uio_in[0] uio_in[1] uio_in[2] uio_in[3] uio_in[4] uio_in[5]
+ uio_in[6] uio_in[7] uio_oe[0] uio_oe[1] uio_oe[2] uio_oe[3] uio_oe[4] uio_oe[5]
+ uio_oe[6] uio_oe[7] uio_out[0] uio_out[1] uio_out[2] uio_out[3] uio_out[4] uio_out[5]
+ uio_out[6] uio_out[7] uo_out[0] uo_out[1] uo_out[2] uo_out[3] uo_out[4] uo_out[5]
+ uo_out[6] uo_out[7] VDPWR VGND VAPWR
* Amplifier: Vp Vn Vmid Vout Rgp Rgn Vref VDD GND
XAMP ua[2] ua[4] VMID ua[0] ua[1] ua[3] ua[5] VAPWR VGND instamp

* Internal Vmid voltage divider
XRVMID_TOP VAPWR VMID VGND sky130_fd_pr__res_xhigh_po_0p35 L=18.33 mult=1 m=1
XRVMID_BOT VMID VGND VGND sky130_fd_pr__res_xhigh_po_0p35 L=18.33 mult=1 m=1
* Unused digital outputs physically tied to VGND
R_UNUSED_GND_uo_out_0 uo_out[0] VGND 0
R_UNUSED_GND_uo_out_1 uo_out[1] VGND 0
R_UNUSED_GND_uo_out_2 uo_out[2] VGND 0
R_UNUSED_GND_uo_out_3 uo_out[3] VGND 0
R_UNUSED_GND_uo_out_4 uo_out[4] VGND 0
R_UNUSED_GND_uo_out_5 uo_out[5] VGND 0
R_UNUSED_GND_uo_out_6 uo_out[6] VGND 0
R_UNUSED_GND_uo_out_7 uo_out[7] VGND 0
R_UNUSED_GND_uio_out_0 uio_out[0] VGND 0
R_UNUSED_GND_uio_out_1 uio_out[1] VGND 0
R_UNUSED_GND_uio_out_2 uio_out[2] VGND 0
R_UNUSED_GND_uio_out_3 uio_out[3] VGND 0
R_UNUSED_GND_uio_out_4 uio_out[4] VGND 0
R_UNUSED_GND_uio_out_5 uio_out[5] VGND 0
R_UNUSED_GND_uio_out_6 uio_out[6] VGND 0
R_UNUSED_GND_uio_out_7 uio_out[7] VGND 0
R_UNUSED_GND_uio_oe_0 uio_oe[0] VGND 0
R_UNUSED_GND_uio_oe_1 uio_oe[1] VGND 0
R_UNUSED_GND_uio_oe_2 uio_oe[2] VGND 0
R_UNUSED_GND_uio_oe_3 uio_oe[3] VGND 0
R_UNUSED_GND_uio_oe_4 uio_oe[4] VGND 0
R_UNUSED_GND_uio_oe_5 uio_oe[5] VGND 0
R_UNUSED_GND_uio_oe_6 uio_oe[6] VGND 0
R_UNUSED_GND_uio_oe_7 uio_oe[7] VGND 0
.ends tt_um_niclemmons_instamp
.end
